# Ansys Electronics Desktop project, version 2025.2
materials:
  vacuum: permittivity=1
  FR4_epoxy: permittivity=4.4 dielectric_loss_tangent=0.02

design HFSSDesign1 (HFSS, HFSS Terminal Network, model units mm)
variables:
  freq_center = 1.5GHz
  L_sub = 100mm
  W_sub = 130mm
  H_cavity = 50mm
  Gap = 2mm
  L_arm = 40mm
  W_arm = 65mm
  R_load = 12ohm
geometry:
  Reflection_Box [vacuum] = box(corner=(-L_sub/2, -W_sub/2, 0mm), size=(L_sub, W_sub, -H_cavity))
  Reflection_Box.detach(Reflection_Box.face(+z))
  Substrate [FR4_epoxy] = box(corner=(-L_sub/2, -W_sub/2, 0mm), size=(L_sub, W_sub, -1.6mm))
  Rectangle1 = rectangle(corner=(-1.7mm, -Gap/2, 0mm), x_size=3.4mm, y_size=Gap)
  RadiatingSurface [vacuum] = region(absolute_offset=125mm on all sides)
  Arm_top = circle(normal=Z, centre=(0mm, L_arm-W_arm/2, 0mm), radius=W_arm/2)
  Rectangle2 = rectangle(corner=(-W_arm/2, Gap/2, 0mm), x_size=W_arm+Gap*2, y_size=L_arm)
  Arm_top.intersect(Rectangle2)
  Arm_top.fillet(Vertices=Arm_top.vertex(at (-31.8434, 1, 0)) Radius=Gap*2 Setback=0mm)
  Arm_top.fillet(Vertices=Arm_top.vertex(at (31.8434, 1, 0)) Radius=Gap*2 Setback=0mm)
  Arm_Bottom = Arm_top.duplicate_around_axis(axis=Z, angle=180deg, total=2)
boundaries and excitations:
  PerfE1: Perfect E Objects=Reflection_Box
  Open1: Radiation Objects=RadiatingSurface
  Imped1: Impedance Objects=[Arm_Bottom, Arm_top] Resistance=R_load Reactance=0
  1: Lumped Port Objects=Rectangle1 LumpedPortType=Modal Modes{Mode1{IntLine{(0, -1, 0) -> (0, 1, 0)} CharImp=Zpi}} Impedance=50ohm
setups:
  Setup1: HfssDrivenAuto AutoSolverSetting=Balanced InfiniteSphereSetup=7 Type=Interpolating
    sweep Sweep: 0.5GHz to 2.5GHz, 401 points;
source amplitudes:
  1:1: 1V 0deg
radiation setups:
  3D: Infinite Sphere Theta=-180deg..180deg step 2deg Phi=-180deg..180deg step 2deg
  Elevation: Infinite Sphere Theta=-180deg..180deg step 1deg Phi=0deg..90deg step 90deg
  Azimuth: Infinite Sphere Theta=90deg..90deg step 0deg Phi=-180deg..180deg step 1deg
  Infinite Sphere1: Infinite Sphere Theta=-180deg..180deg step 2deg Phi=0deg..360deg step 2deg
