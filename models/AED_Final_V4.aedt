# Ansys Electronics Desktop project, version 2025.2
materials:
  vacuum: permittivity=1
  FR4_epoxy: permittivity=4.4 dielectric_loss_tangent=0.02
  copper: permeability=0.999991 conductivity=58000000
  perfect conductor: conductivity=1e+30
  Absorber_Mat: dielectric_loss_tangent=0.5

design HFSSDesign1 (HFSS, HFSS Modal Network, model units mm)
variables:
  Sub_W = 740mm
  Sub_L = 320mm
  H_Sub = 1.6mm
  R_Long = 175mm
  R_Short = 110mm
  Offset = 3mm
  W_Neck = 1.8mm
  H_Cav = 60mm
  W_SMA = 3mm
  W_GND = 30mm
  W_Ring = 10mm
  R_Resist = 1mm
  H_Loss = 45mm
  Resist = 85ohm
geometry:
  Substrate [FR4_epoxy] = box(corner=(-Sub_W/2, -Sub_L/2, 0mm), size=(Sub_W, Sub_L, H_Sub))
  RND_Ring_And_Antenna_Bottom = rectangle(corner=(-Sub_W/2, -Sub_L/2, 0mm), x_size=Sub_W, y_size=Sub_L)
  Rectangle2 = rectangle(corner=(-(Sub_W/2-W_Ring), -(Sub_L/2 - W_Ring), 0mm), x_size=Sub_W - 2*W_Ring, y_size=Sub_L - 2*W_Ring)
  RND_Ring_And_Antenna_Bottom.subtract(Rectangle2)
  Polyline1 = polyline(z=H_Sub, xy: (-W_SMA/2, -Sub_L/2) (W_SMA/2, -Sub_L/2) (W_Neck/2, 0mm) (-W_Neck/2, 0mm) (-W_SMA/2, -Sub_L/2), closed, covered)
  Rectangle3 = rectangle(corner=(-W_Neck/2, -W_Neck/2, H_Sub), x_size=W_Neck/2 + Offset+10mm, y_size=W_Neck)
  Antenna_Top = ellipse(normal=Z, centre=(Offset+R_Long, 0mm, H_Sub), major_radius=R_Long, ratio=R_Short/R_Long)
  Antenna_Top.unite(Polyline1, Rectangle3)
  Polyline2 = polyline(z=0mm, xy: (-W_GND/2, -Sub_L/2) (W_GND/2, -Sub_L/2) (W_Neck/2, 0mm) (-W_Neck/2, 0mm) (-W_GND/2, -Sub_L/2), closed, covered)
  Rectangle4 = rectangle(corner=(W_Neck/2, -W_Neck/2, 0mm), x_size=-(W_Neck/2+Offset+10mm), y_size=W_Neck)
  Antenna_Bottom = ellipse(normal=Z, centre=(-(Offset+R_Long), 0mm, 0mm), major_radius=R_Long, ratio=R_Short/R_Long)
  Antenna_Bottom.unite(Polyline2, Rectangle4)
  RND_Ring_And_Antenna_Bottom.unite(Antenna_Bottom)
  Port = rectangle(corner=(-W_SMA/2, -Sub_L/2, H_Sub), z_size=-H_Sub, x_size=W_SMA)
  RadiatingSurface [vacuum] = region(absolute_offset=125mm on all sides)
  Cavity [vacuum] = box(corner=(-(Sub_W/2 - W_Ring/2), -(Sub_L/2 - W_Ring/2), -H_Cav), size=(Sub_W-W_Ring, Sub_L -W_Ring, H_Cav))
  Cavity.uncover_faces(FacesToUncover=Cavity.face(+z))
  Resist_Top [vacuum] = cylinder(axis=Z, base_centre=(Offset+2*R_Long+2*R_Resist, 0mm, H_Sub), radius=R_Resist, height=-(H_Cav+H_Sub))
  Resist_Bottom [vacuum] = cylinder(axis=Z, base_centre=(-(Offset+2*R_Long+2*R_Resist), 0mm, 0mm), radius=R_Resist, height=-H_Cav)
  Absorber [Absorber_Mat] = box(corner=(-(Sub_W/2 - W_Ring/2), -(Sub_L/2 - W_Ring/2), -H_Cav), size=(Sub_W-W_Ring, Sub_L-W_Ring, H_Loss))
  Cavity.thicken(1mm)
  Resistor_Top = rectangle(corner=(Offset+2*R_Long+2*R_Resist, 0.5mm, H_Sub), x_size=-2*W_Neck, y_size=-1mm)
  Resistor_Bottom = rectangle(corner=(-(Offset+2*R_Long+2*R_Resist), -1mm, 0mm), x_size=3*W_Neck, y_size=2mm)
  Antenna_Top_1 = Antenna_Top.copy()
  Resist_Top_1 = Resist_Top.copy()
  Resistor_Top.subtract(Antenna_Top_1, Resist_Top_1)
  Resist_Bottom_1 = Resist_Bottom.copy()
  RND_Ring_And_Antenna_Bottom_1 = RND_Ring_And_Antenna_Bottom.copy()
  Resistor_Bottom.subtract(Resist_Bottom_1, RND_Ring_And_Antenna_Bottom_1)
  Resist_Bottom_2 = Resist_Bottom.copy()
  Resist_Top_2 = Resist_Top.copy()
  Absorber.subtract(Resist_Bottom_2, Resist_Top_2)
  Resist_Top_3 = Resist_Top.copy()
  Substrate.subtract(Resist_Top_3)
boundaries and excitations:
  FiniteCond1: Finite Conductivity Objects=Antenna_Top UseMaterial Material=copper IsInternal
  Open1: Radiation Objects=RadiatingSurface
  LumpRLC1: Lumped RLC Objects=Resistor_Top CurrentLine{(353, 0, 1.6) -> (354, 0, 1.6)} RLC_Type=Parallel Resistance=Resist
  LumpRLC2: Lumped RLC Objects=Resistor_Bottom CurrentLine{(-353, 0, 0) -> (-354, 0, 0)} RLC_Type=Parallel Resistance=Resist
  PerfE2: Perfect E Objects=[RND_Ring_And_Antenna_Bottom, Cavity, Resist_Bottom, Resist_Top]
  1: Lumped Port Objects=Port LumpedPortType=Modal Modes{Mode1{IntLine{(0, -160, 0) -> (0, -160, 1.6)} CharImp=Zpi}} Impedance=50ohm
setups:
  Setup1: HfssDrivenAuto AutoSolverSetting="Higher Speed" InfiniteSphereSetup=1 Type=Interpolating
    sweep Sweep: 0.5GHz to 2.5GHz, 201 points;
source amplitudes:
  1:1: 1W 0deg
radiation setups:
  3D: Infinite Sphere Theta=-180deg..180deg step 2deg Phi=-180deg..180deg step 2deg
  Elevation: Infinite Sphere Theta=-180deg..180deg step 1deg Phi=0deg..90deg step 90deg
  Azimuth: Infinite Sphere Theta=90deg..90deg step 0deg Phi=-180deg..180deg step 1deg
reports:
  S Parameter Plot1: dB(S(1,1)) vs Freq on Setup1 : Sweep [Sub_L=all R_Short=110mm Offset=3mm W_Neck=1.8mm]
  Gain Plot1: dB(GainTotal) vs Theta on Setup1 : LastAdaptive, 3D [Phi=90deg Freq=1.5GHz]
  Gain Plot2: dB(GainTotal) vs Phi, Theta on Setup1 : LastAdaptive, 3D [Freq=1.5GHz]
